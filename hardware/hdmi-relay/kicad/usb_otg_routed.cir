* usb_otg_routed
Vs in 0 PWL(0 0 6.2500e-10 -0.4 2.0833e-09 -0.4 2.7083e-09 -0.4 4.1667e-09 -0.4 4.7917e-09 -0.4 6.2500e-09 -0.4 6.8750e-09 -0.4 8.3333e-09 -0.4 8.9583e-09 -0.4 1.0417e-08 -0.4 1.1042e-08 -0.4 1.2500e-08 -0.4 1.3125e-08 0.4 1.4583e-08 0.4 1.5208e-08 -0.4 1.6667e-08 -0.4 1.7292e-08 -0.4 1.8750e-08 -0.4 1.9375e-08 -0.4 2.0833e-08 -0.4 2.1458e-08 -0.4 2.2917e-08 -0.4 2.3542e-08 -0.4 2.5000e-08 -0.4 2.5625e-08 0.4 2.7083e-08 0.4 2.7708e-08 0.4 2.9167e-08 0.4 2.9792e-08 -0.4 3.1250e-08 -0.4 3.1875e-08 -0.4 3.3333e-08 -0.4 3.3958e-08 -0.4 3.5417e-08 -0.4 3.6042e-08 -0.4 3.7500e-08 -0.4 3.8125e-08 0.4 3.9583e-08 0.4 4.0208e-08 -0.4 4.1667e-08 -0.4 4.2292e-08 0.4 4.3750e-08 0.4 4.4375e-08 -0.4 4.5833e-08 -0.4 4.6458e-08 -0.4 4.7917e-08 -0.4 4.8542e-08 -0.4 5.0000e-08 -0.4 5.0625e-08 0.4 5.2083e-08 0.4 5.2708e-08 0.4 5.4167e-08 0.4 5.4792e-08 0.4 5.6250e-08 0.4 5.6875e-08 0.4 5.8333e-08 0.4 5.8958e-08 -0.4 6.0417e-08 -0.4 6.1042e-08 -0.4 6.2500e-08 -0.4 6.3125e-08 0.4 6.4583e-08 0.4 6.5208e-08 -0.4 6.6667e-08 -0.4 6.7292e-08 -0.4 6.8750e-08 -0.4 6.9375e-08 -0.4 7.0833e-08 -0.4 7.1458e-08 0.4 7.2917e-08 0.4 7.3542e-08 -0.4 7.5000e-08 -0.4 7.5625e-08 0.4 7.7083e-08 0.4 7.7708e-08 0.4 7.9167e-08 0.4 7.9792e-08 -0.4 8.1250e-08 -0.4 8.1875e-08 -0.4 8.3333e-08 -0.4 8.3958e-08 0.4 8.5417e-08 0.4 8.6042e-08 0.4 8.7500e-08 0.4 8.8125e-08 0.4 8.9583e-08 0.4 9.0208e-08 -0.4 9.1667e-08 -0.4 9.2292e-08 0.4 9.3750e-08 0.4 9.4375e-08 -0.4 9.5833e-08 -0.4 9.6458e-08 0.4 9.7917e-08 0.4 9.8542e-08 -0.4 1.0000e-07 -0.4 1.0063e-07 -0.4 1.0208e-07 -0.4 1.0271e-07 0.4 1.0417e-07 0.4 1.0479e-07 0.4 1.0625e-07 0.4 1.0688e-07 0.4 1.0833e-07 0.4 1.0896e-07 0.4 1.1042e-07 0.4 1.1104e-07 0.4 1.1250e-07 0.4 1.1313e-07 -0.4 1.1458e-07 -0.4 1.1521e-07 0.4 1.1667e-07 0.4 1.1729e-07 -0.4 1.1875e-07 -0.4 1.1938e-07 -0.4 1.2083e-07 -0.4 1.2146e-07 -0.4 1.2292e-07 -0.4 1.2354e-07 -0.4 1.2500e-07 -0.4 1.2563e-07 0.4 1.2708e-07 0.4 1.2771e-07 0.4 1.2917e-07 0.4 1.2979e-07 0.4 1.3125e-07 0.4 1.3188e-07 -0.4 1.3333e-07 -0.4 1.3396e-07 -0.4 1.3542e-07 -0.4 1.3604e-07 -0.4 1.3750e-07 -0.4 1.3812e-07 0.4 1.3958e-07 0.4 1.4021e-07 -0.4 1.4167e-07 -0.4 1.4229e-07 -0.4 1.4375e-07 -0.4 1.4437e-07 0.4 1.4583e-07 0.4 1.4646e-07 -0.4 1.4792e-07 -0.4 1.4854e-07 -0.4 1.5000e-07 -0.4 1.5062e-07 0.4 1.5208e-07 0.4 1.5271e-07 0.4 1.5417e-07 0.4 1.5479e-07 -0.4 1.5625e-07 -0.4 1.5687e-07 0.4 1.5833e-07 0.4 1.5896e-07 0.4 1.6042e-07 0.4 1.6104e-07 -0.4 1.6250e-07 -0.4 1.6312e-07 0.4 1.6458e-07 0.4 1.6521e-07 -0.4 1.6667e-07 -0.4 1.6729e-07 0.4 1.6875e-07 0.4 1.6937e-07 0.4 1.7083e-07 0.4 1.7146e-07 -0.4 1.7292e-07 -0.4 1.7354e-07 0.4 1.7500e-07 0.4 1.7562e-07 0.4 1.7708e-07 0.4 1.7771e-07 0.4 1.7917e-07 0.4 1.7979e-07 0.4 1.8125e-07 0.4 1.8187e-07 -0.4 1.8333e-07 -0.4 1.8396e-07 0.4 1.8542e-07 0.4 1.8604e-07 0.4 1.8750e-07 0.4 1.8812e-07 -0.4 1.8958e-07 -0.4 1.9021e-07 -0.4 1.9167e-07 -0.4 1.9229e-07 -0.4 1.9375e-07 -0.4 1.9437e-07 0.4 1.9583e-07 0.4 1.9646e-07 0.4 1.9792e-07 0.4 1.9854e-07 -0.4 2.0000e-07 -0.4 2.0062e-07 0.4 2.0208e-07 0.4 2.0271e-07 -0.4 2.0417e-07 -0.4 2.0479e-07 -0.4 2.0625e-07 -0.4 2.0687e-07 0.4 2.0833e-07 0.4 2.0896e-07 -0.4 2.1042e-07 -0.4 2.1104e-07 0.4 2.1250e-07 0.4 2.1312e-07 0.4 2.1458e-07 0.4 2.1521e-07 0.4 2.1667e-07 0.4 2.1729e-07 -0.4 2.1875e-07 -0.4 2.1937e-07 0.4 2.2083e-07 0.4 2.2146e-07 0.4 2.2292e-07 0.4 2.2354e-07 0.4 2.2500e-07 0.4 2.2562e-07 -0.4 2.2708e-07 -0.4 2.2771e-07 -0.4 2.2917e-07 -0.4 2.2979e-07 0.4 2.3125e-07 0.4 2.3187e-07 0.4 2.3333e-07 0.4 2.3396e-07 -0.4 2.3542e-07 -0.4 2.3604e-07 -0.4 2.3750e-07 -0.4 2.3812e-07 0.4 2.3958e-07 0.4 2.4021e-07 -0.4 2.4167e-07 -0.4 2.4229e-07 0.4 2.4375e-07 0.4 2.4437e-07 -0.4 2.4583e-07 -0.4 2.4646e-07 0.4 2.4792e-07 0.4 2.4854e-07 -0.4 2.5000e-07 -0.4 2.5062e-07 0.4 2.5208e-07 0.4 2.5271e-07 0.4 2.5417e-07 0.4 2.5479e-07 0.4 2.5625e-07 0.4 2.5687e-07 0.4 2.5833e-07 0.4 2.5896e-07 0.4 2.6042e-07 0.4 2.6104e-07 0.4 2.6250e-07 0.4 2.6312e-07 0.4 2.6458e-07 0.4 2.6521e-07 -0.4 2.6667e-07 -0.4 2.6729e-07 -0.4 2.6875e-07 -0.4 2.6937e-07 -0.4 2.7083e-07 -0.4 2.7146e-07 -0.4 2.7292e-07 -0.4 2.7354e-07 -0.4 2.7500e-07 -0.4 2.7562e-07 -0.4 2.7708e-07 -0.4 2.7771e-07 0.4 2.7917e-07 0.4 2.7979e-07 -0.4 2.8125e-07 -0.4 2.8187e-07 -0.4 2.8333e-07 -0.4 2.8396e-07 -0.4 2.8542e-07 -0.4 2.8604e-07 -0.4 2.8750e-07 -0.4 2.8812e-07 -0.4 2.8958e-07 -0.4 2.9021e-07 0.4 2.9167e-07 0.4 2.9229e-07 0.4 2.9375e-07 0.4 2.9437e-07 -0.4 2.9583e-07 -0.4 2.9646e-07 -0.4 2.9792e-07 -0.4 2.9854e-07 -0.4 3.0000e-07 -0.4 3.0062e-07 -0.4 3.0208e-07 -0.4 3.0271e-07 0.4 3.0417e-07 0.4 3.0479e-07 -0.4 3.0625e-07 -0.4 3.0687e-07 0.4 3.0833e-07 0.4 3.0896e-07 -0.4 3.1042e-07 -0.4 3.1104e-07 -0.4 3.1250e-07 -0.4 3.1312e-07 -0.4 3.1458e-07 -0.4 3.1521e-07 0.4 3.1667e-07 0.4 3.1729e-07 0.4 3.1875e-07 0.4 3.1938e-07 0.4 3.2083e-07 0.4 3.2146e-07 0.4 3.2292e-07 0.4 3.2354e-07 -0.4 3.2500e-07 -0.4 3.2563e-07 -0.4 3.2708e-07 -0.4 3.2771e-07 0.4 3.2917e-07 0.4 3.2979e-07 -0.4 3.3125e-07 -0.4 3.3188e-07 -0.4 3.3333e-07 -0.4 3.3396e-07 -0.4 3.3542e-07 -0.4 3.3604e-07 0.4 3.3750e-07 0.4 3.3813e-07 -0.4 3.3958e-07 -0.4 3.4021e-07 0.4 3.4167e-07 0.4 3.4229e-07 0.4 3.4375e-07 0.4 3.4438e-07 -0.4 3.4583e-07 -0.4 3.4646e-07 -0.4 3.4792e-07 -0.4 3.4854e-07 0.4 3.5000e-07 0.4 3.5063e-07 0.4 3.5208e-07 0.4 3.5271e-07 0.4 3.5417e-07 0.4 3.5479e-07 -0.4 3.5625e-07 -0.4 3.5688e-07 0.4 3.5833e-07 0.4 3.5896e-07 -0.4 3.6042e-07 -0.4 3.6104e-07 0.4 3.6250e-07 0.4 3.6313e-07 -0.4 3.6458e-07 -0.4 3.6521e-07 -0.4 3.6667e-07 -0.4 3.6729e-07 0.4 3.6875e-07 0.4 3.6938e-07 0.4 3.7083e-07 0.4 3.7146e-07 0.4 3.7292e-07 0.4 3.7354e-07 0.4 3.7500e-07 0.4 3.7563e-07 0.4 3.7708e-07 0.4 3.7771e-07 -0.4 3.7917e-07 -0.4 3.7979e-07 0.4 3.8125e-07 0.4 3.8188e-07 -0.4 3.8333e-07 -0.4 3.8396e-07 -0.4 3.8542e-07 -0.4 3.8604e-07 -0.4 3.8750e-07 -0.4 3.8813e-07 -0.4 3.8958e-07 -0.4 3.9021e-07 0.4 3.9167e-07 0.4 3.9229e-07 0.4 3.9375e-07 0.4 3.9438e-07 0.4 3.9583e-07 0.4 3.9646e-07 -0.4 3.9792e-07 -0.4 3.9854e-07 -0.4 4.0000e-07 -0.4 4.0063e-07 -0.4 4.0208e-07 -0.4 4.0271e-07 0.4 4.0417e-07 0.4 4.0479e-07 -0.4 4.0625e-07 -0.4 4.0688e-07 -0.4 4.0833e-07 -0.4 4.0896e-07 0.4 4.1042e-07 0.4 4.1104e-07 -0.4 4.1250e-07 -0.4 4.1313e-07 -0.4 4.1458e-07 -0.4 4.1521e-07 0.4 4.1667e-07 0.4 4.1729e-07 0.4 4.1875e-07 0.4 4.1938e-07 -0.4 4.2083e-07 -0.4 4.2146e-07 0.4 4.2292e-07 0.4 4.2354e-07 0.4 4.2500e-07 0.4 4.2563e-07 -0.4 4.2708e-07 -0.4 4.2771e-07 0.4 4.2917e-07 0.4 4.2979e-07 -0.4 4.3125e-07 -0.4 4.3188e-07 0.4 4.3333e-07 0.4 4.3396e-07 0.4 4.3542e-07 0.4 4.3604e-07 -0.4 4.3750e-07 -0.4 4.3813e-07 0.4 4.3958e-07 0.4 4.4021e-07 0.4 4.4167e-07 0.4 4.4229e-07 0.4 4.4375e-07 0.4 4.4438e-07 0.4 4.4583e-07 0.4 4.4646e-07 -0.4 4.4792e-07 -0.4 4.4854e-07 0.4 4.5000e-07 0.4 4.5063e-07 0.4 4.5208e-07 0.4 4.5271e-07 -0.4 4.5417e-07 -0.4 4.5479e-07 -0.4 4.5625e-07 -0.4 4.5688e-07 -0.4 4.5833e-07 -0.4 4.5896e-07 0.4 4.6042e-07 0.4 4.6104e-07 0.4 4.6250e-07 0.4 4.6313e-07 -0.4 4.6458e-07 -0.4 4.6521e-07 0.4 4.6667e-07 0.4 4.6729e-07 -0.4 4.6875e-07 -0.4 4.6938e-07 -0.4 4.7083e-07 -0.4 4.7146e-07 0.4 4.7292e-07 0.4 4.7354e-07 -0.4 4.7500e-07 -0.4 4.7563e-07 0.4 4.7708e-07 0.4 4.7771e-07 0.4 4.7917e-07 0.4 4.7979e-07 0.4 4.8125e-07 0.4 4.8188e-07 -0.4 4.8333e-07 -0.4 4.8396e-07 0.4 4.8542e-07 0.4 4.8604e-07 0.4 4.8750e-07 0.4 4.8813e-07 0.4 4.8958e-07 0.4 4.9021e-07 -0.4 4.9167e-07 -0.4 4.9229e-07 -0.4 4.9375e-07 -0.4 4.9438e-07 0.4 4.9583e-07 0.4 4.9646e-07 0.4 4.9792e-07 0.4 4.9854e-07 -0.4 5.0000e-07 -0.4 5.0063e-07 -0.4 5.0208e-07 -0.4 5.0271e-07 0.4 5.0417e-07 0.4 5.0479e-07 -0.4 5.0625e-07 -0.4 5.0688e-07 0.4 5.0833e-07 0.4 5.0896e-07 -0.4 5.1042e-07 -0.4 5.1104e-07 0.4 5.1250e-07 0.4 5.1313e-07 -0.4 5.1458e-07 -0.4 5.1521e-07 0.4 5.1667e-07 0.4 5.1729e-07 0.4 5.1875e-07 0.4 5.1938e-07 0.4 5.2083e-07 0.4 5.2146e-07 0.4 5.2292e-07 0.4 5.2354e-07 0.4 5.2500e-07 0.4 5.2563e-07 0.4 5.2708e-07 0.4 5.2771e-07 0.4 5.2917e-07 0.4)
Rs in a 45
T1 a 0 b 0 Z0=54.4 TD=4.8034e-10
Rl b 0 45
.tran 5.208e-11 5.2917e-07
.control
run
wrdata out_usb_otg_routed.txt v(b)
quit
.endc
.end
