* pcie_tx_matched
Vs in 0 PWL(0 0 6.0000e-11 -0.4 2.0000e-10 -0.4 2.6000e-10 -0.4 4.0000e-10 -0.4 4.6000e-10 -0.4 6.0000e-10 -0.4 6.6000e-10 -0.4 8.0000e-10 -0.4 8.6000e-10 -0.4 1.0000e-09 -0.4 1.0600e-09 -0.4 1.2000e-09 -0.4 1.2600e-09 0.4 1.4000e-09 0.4 1.4600e-09 -0.4 1.6000e-09 -0.4 1.6600e-09 -0.4 1.8000e-09 -0.4 1.8600e-09 -0.4 2.0000e-09 -0.4 2.0600e-09 -0.4 2.2000e-09 -0.4 2.2600e-09 -0.4 2.4000e-09 -0.4 2.4600e-09 0.4 2.6000e-09 0.4 2.6600e-09 0.4 2.8000e-09 0.4 2.8600e-09 -0.4 3.0000e-09 -0.4 3.0600e-09 -0.4 3.2000e-09 -0.4 3.2600e-09 -0.4 3.4000e-09 -0.4 3.4600e-09 -0.4 3.6000e-09 -0.4 3.6600e-09 0.4 3.8000e-09 0.4 3.8600e-09 -0.4 4.0000e-09 -0.4 4.0600e-09 0.4 4.2000e-09 0.4 4.2600e-09 -0.4 4.4000e-09 -0.4 4.4600e-09 -0.4 4.6000e-09 -0.4 4.6600e-09 -0.4 4.8000e-09 -0.4 4.8600e-09 0.4 5.0000e-09 0.4 5.0600e-09 0.4 5.2000e-09 0.4 5.2600e-09 0.4 5.4000e-09 0.4 5.4600e-09 0.4 5.6000e-09 0.4 5.6600e-09 -0.4 5.8000e-09 -0.4 5.8600e-09 -0.4 6.0000e-09 -0.4 6.0600e-09 0.4 6.2000e-09 0.4 6.2600e-09 -0.4 6.4000e-09 -0.4 6.4600e-09 -0.4 6.6000e-09 -0.4 6.6600e-09 -0.4 6.8000e-09 -0.4 6.8600e-09 0.4 7.0000e-09 0.4 7.0600e-09 -0.4 7.2000e-09 -0.4 7.2600e-09 0.4 7.4000e-09 0.4 7.4600e-09 0.4 7.6000e-09 0.4 7.6600e-09 -0.4 7.8000e-09 -0.4 7.8600e-09 -0.4 8.0000e-09 -0.4 8.0600e-09 0.4 8.2000e-09 0.4 8.2600e-09 0.4 8.4000e-09 0.4 8.4600e-09 0.4 8.6000e-09 0.4 8.6600e-09 -0.4 8.8000e-09 -0.4 8.8600e-09 0.4 9.0000e-09 0.4 9.0600e-09 -0.4 9.2000e-09 -0.4 9.2600e-09 0.4 9.4000e-09 0.4 9.4600e-09 -0.4 9.6000e-09 -0.4 9.6600e-09 -0.4 9.8000e-09 -0.4 9.8600e-09 0.4 1.0000e-08 0.4 1.0060e-08 0.4 1.0200e-08 0.4 1.0260e-08 0.4 1.0400e-08 0.4 1.0460e-08 0.4 1.0600e-08 0.4 1.0660e-08 0.4 1.0800e-08 0.4 1.0860e-08 -0.4 1.1000e-08 -0.4 1.1060e-08 0.4 1.1200e-08 0.4 1.1260e-08 -0.4 1.1400e-08 -0.4 1.1460e-08 -0.4 1.1600e-08 -0.4 1.1660e-08 -0.4 1.1800e-08 -0.4 1.1860e-08 -0.4 1.2000e-08 -0.4 1.2060e-08 0.4 1.2200e-08 0.4 1.2260e-08 0.4 1.2400e-08 0.4 1.2460e-08 0.4 1.2600e-08 0.4 1.2660e-08 -0.4 1.2800e-08 -0.4 1.2860e-08 -0.4 1.3000e-08 -0.4 1.3060e-08 -0.4 1.3200e-08 -0.4 1.3260e-08 0.4 1.3400e-08 0.4 1.3460e-08 -0.4 1.3600e-08 -0.4 1.3660e-08 -0.4 1.3800e-08 -0.4 1.3860e-08 0.4 1.4000e-08 0.4 1.4060e-08 -0.4 1.4200e-08 -0.4 1.4260e-08 -0.4 1.4400e-08 -0.4 1.4460e-08 0.4 1.4600e-08 0.4 1.4660e-08 0.4 1.4800e-08 0.4 1.4860e-08 -0.4 1.5000e-08 -0.4 1.5060e-08 0.4 1.5200e-08 0.4 1.5260e-08 0.4 1.5400e-08 0.4 1.5460e-08 -0.4 1.5600e-08 -0.4 1.5660e-08 0.4 1.5800e-08 0.4 1.5860e-08 -0.4 1.6000e-08 -0.4 1.6060e-08 0.4 1.6200e-08 0.4 1.6260e-08 0.4 1.6400e-08 0.4 1.6460e-08 -0.4 1.6600e-08 -0.4 1.6660e-08 0.4 1.6800e-08 0.4 1.6860e-08 0.4 1.7000e-08 0.4 1.7060e-08 0.4 1.7200e-08 0.4 1.7260e-08 0.4 1.7400e-08 0.4 1.7460e-08 -0.4 1.7600e-08 -0.4 1.7660e-08 0.4 1.7800e-08 0.4 1.7860e-08 0.4 1.8000e-08 0.4 1.8060e-08 -0.4 1.8200e-08 -0.4 1.8260e-08 -0.4 1.8400e-08 -0.4 1.8460e-08 -0.4 1.8600e-08 -0.4 1.8660e-08 0.4 1.8800e-08 0.4 1.8860e-08 0.4 1.9000e-08 0.4 1.9060e-08 -0.4 1.9200e-08 -0.4 1.9260e-08 0.4 1.9400e-08 0.4 1.9460e-08 -0.4 1.9600e-08 -0.4 1.9660e-08 -0.4 1.9800e-08 -0.4 1.9860e-08 0.4 2.0000e-08 0.4 2.0060e-08 -0.4 2.0200e-08 -0.4 2.0260e-08 0.4 2.0400e-08 0.4 2.0460e-08 0.4 2.0600e-08 0.4 2.0660e-08 0.4 2.0800e-08 0.4 2.0860e-08 -0.4 2.1000e-08 -0.4 2.1060e-08 0.4 2.1200e-08 0.4 2.1260e-08 0.4 2.1400e-08 0.4 2.1460e-08 0.4 2.1600e-08 0.4 2.1660e-08 -0.4 2.1800e-08 -0.4 2.1860e-08 -0.4 2.2000e-08 -0.4 2.2060e-08 0.4 2.2200e-08 0.4 2.2260e-08 0.4 2.2400e-08 0.4 2.2460e-08 -0.4 2.2600e-08 -0.4 2.2660e-08 -0.4 2.2800e-08 -0.4 2.2860e-08 0.4 2.3000e-08 0.4 2.3060e-08 -0.4 2.3200e-08 -0.4 2.3260e-08 0.4 2.3400e-08 0.4 2.3460e-08 -0.4 2.3600e-08 -0.4 2.3660e-08 0.4 2.3800e-08 0.4 2.3860e-08 -0.4 2.4000e-08 -0.4 2.4060e-08 0.4 2.4200e-08 0.4 2.4260e-08 0.4 2.4400e-08 0.4 2.4460e-08 0.4 2.4600e-08 0.4 2.4660e-08 0.4 2.4800e-08 0.4 2.4860e-08 0.4 2.5000e-08 0.4 2.5060e-08 0.4 2.5200e-08 0.4 2.5260e-08 0.4 2.5400e-08 0.4 2.5460e-08 -0.4 2.5600e-08 -0.4 2.5660e-08 -0.4 2.5800e-08 -0.4 2.5860e-08 -0.4 2.6000e-08 -0.4 2.6060e-08 -0.4 2.6200e-08 -0.4 2.6260e-08 -0.4 2.6400e-08 -0.4 2.6460e-08 -0.4 2.6600e-08 -0.4 2.6660e-08 0.4 2.6800e-08 0.4 2.6860e-08 -0.4 2.7000e-08 -0.4 2.7060e-08 -0.4 2.7200e-08 -0.4 2.7260e-08 -0.4 2.7400e-08 -0.4 2.7460e-08 -0.4 2.7600e-08 -0.4 2.7660e-08 -0.4 2.7800e-08 -0.4 2.7860e-08 0.4 2.8000e-08 0.4 2.8060e-08 0.4 2.8200e-08 0.4 2.8260e-08 -0.4 2.8400e-08 -0.4 2.8460e-08 -0.4 2.8600e-08 -0.4 2.8660e-08 -0.4 2.8800e-08 -0.4 2.8860e-08 -0.4 2.9000e-08 -0.4 2.9060e-08 0.4 2.9200e-08 0.4 2.9260e-08 -0.4 2.9400e-08 -0.4 2.9460e-08 0.4 2.9600e-08 0.4 2.9660e-08 -0.4 2.9800e-08 -0.4 2.9860e-08 -0.4 3.0000e-08 -0.4 3.0060e-08 -0.4 3.0200e-08 -0.4 3.0260e-08 0.4 3.0400e-08 0.4 3.0460e-08 0.4 3.0600e-08 0.4 3.0660e-08 0.4 3.0800e-08 0.4 3.0860e-08 0.4 3.1000e-08 0.4 3.1060e-08 -0.4 3.1200e-08 -0.4 3.1260e-08 -0.4 3.1400e-08 -0.4 3.1460e-08 0.4 3.1600e-08 0.4 3.1660e-08 -0.4 3.1800e-08 -0.4 3.1860e-08 -0.4 3.2000e-08 -0.4 3.2060e-08 -0.4 3.2200e-08 -0.4 3.2260e-08 0.4 3.2400e-08 0.4 3.2460e-08 -0.4 3.2600e-08 -0.4 3.2660e-08 0.4 3.2800e-08 0.4 3.2860e-08 0.4 3.3000e-08 0.4 3.3060e-08 -0.4 3.3200e-08 -0.4 3.3260e-08 -0.4 3.3400e-08 -0.4 3.3460e-08 0.4 3.3600e-08 0.4 3.3660e-08 0.4 3.3800e-08 0.4 3.3860e-08 0.4 3.4000e-08 0.4 3.4060e-08 -0.4 3.4200e-08 -0.4 3.4260e-08 0.4 3.4400e-08 0.4 3.4460e-08 -0.4 3.4600e-08 -0.4 3.4660e-08 0.4 3.4800e-08 0.4 3.4860e-08 -0.4 3.5000e-08 -0.4 3.5060e-08 -0.4 3.5200e-08 -0.4 3.5260e-08 0.4 3.5400e-08 0.4 3.5460e-08 0.4 3.5600e-08 0.4 3.5660e-08 0.4 3.5800e-08 0.4 3.5860e-08 0.4 3.6000e-08 0.4 3.6060e-08 0.4 3.6200e-08 0.4 3.6260e-08 -0.4 3.6400e-08 -0.4 3.6460e-08 0.4 3.6600e-08 0.4 3.6660e-08 -0.4 3.6800e-08 -0.4 3.6860e-08 -0.4 3.7000e-08 -0.4 3.7060e-08 -0.4 3.7200e-08 -0.4 3.7260e-08 -0.4 3.7400e-08 -0.4 3.7460e-08 0.4 3.7600e-08 0.4 3.7660e-08 0.4 3.7800e-08 0.4 3.7860e-08 0.4 3.8000e-08 0.4 3.8060e-08 -0.4 3.8200e-08 -0.4 3.8260e-08 -0.4 3.8400e-08 -0.4 3.8460e-08 -0.4 3.8600e-08 -0.4 3.8660e-08 0.4 3.8800e-08 0.4 3.8860e-08 -0.4 3.9000e-08 -0.4 3.9060e-08 -0.4 3.9200e-08 -0.4 3.9260e-08 0.4 3.9400e-08 0.4 3.9460e-08 -0.4 3.9600e-08 -0.4 3.9660e-08 -0.4 3.9800e-08 -0.4 3.9860e-08 0.4 4.0000e-08 0.4 4.0060e-08 0.4 4.0200e-08 0.4 4.0260e-08 -0.4 4.0400e-08 -0.4 4.0460e-08 0.4 4.0600e-08 0.4 4.0660e-08 0.4 4.0800e-08 0.4 4.0860e-08 -0.4 4.1000e-08 -0.4 4.1060e-08 0.4 4.1200e-08 0.4 4.1260e-08 -0.4 4.1400e-08 -0.4 4.1460e-08 0.4 4.1600e-08 0.4 4.1660e-08 0.4 4.1800e-08 0.4 4.1860e-08 -0.4 4.2000e-08 -0.4 4.2060e-08 0.4 4.2200e-08 0.4 4.2260e-08 0.4 4.2400e-08 0.4 4.2460e-08 0.4 4.2600e-08 0.4 4.2660e-08 0.4 4.2800e-08 0.4 4.2860e-08 -0.4 4.3000e-08 -0.4 4.3060e-08 0.4 4.3200e-08 0.4 4.3260e-08 0.4 4.3400e-08 0.4 4.3460e-08 -0.4 4.3600e-08 -0.4 4.3660e-08 -0.4 4.3800e-08 -0.4 4.3860e-08 -0.4 4.4000e-08 -0.4 4.4060e-08 0.4 4.4200e-08 0.4 4.4260e-08 0.4 4.4400e-08 0.4 4.4460e-08 -0.4 4.4600e-08 -0.4 4.4660e-08 0.4 4.4800e-08 0.4 4.4860e-08 -0.4 4.5000e-08 -0.4 4.5060e-08 -0.4 4.5200e-08 -0.4 4.5260e-08 0.4 4.5400e-08 0.4 4.5460e-08 -0.4 4.5600e-08 -0.4 4.5660e-08 0.4 4.5800e-08 0.4 4.5860e-08 0.4 4.6000e-08 0.4 4.6060e-08 0.4 4.6200e-08 0.4 4.6260e-08 -0.4 4.6400e-08 -0.4 4.6460e-08 0.4 4.6600e-08 0.4 4.6660e-08 0.4 4.6800e-08 0.4 4.6860e-08 0.4 4.7000e-08 0.4 4.7060e-08 -0.4 4.7200e-08 -0.4 4.7260e-08 -0.4 4.7400e-08 -0.4 4.7460e-08 0.4 4.7600e-08 0.4 4.7660e-08 0.4 4.7800e-08 0.4 4.7860e-08 -0.4 4.8000e-08 -0.4 4.8060e-08 -0.4 4.8200e-08 -0.4 4.8260e-08 0.4 4.8400e-08 0.4 4.8460e-08 -0.4 4.8600e-08 -0.4 4.8660e-08 0.4 4.8800e-08 0.4 4.8860e-08 -0.4 4.9000e-08 -0.4 4.9060e-08 0.4 4.9200e-08 0.4 4.9260e-08 -0.4 4.9400e-08 -0.4 4.9460e-08 0.4 4.9600e-08 0.4 4.9660e-08 0.4 4.9800e-08 0.4 4.9860e-08 0.4 5.0000e-08 0.4 5.0060e-08 0.4 5.0200e-08 0.4 5.0260e-08 0.4 5.0400e-08 0.4 5.0460e-08 0.4 5.0600e-08 0.4 5.0660e-08 0.4 5.0800e-08 0.4)
Rs in a 42.5
T1 a 0 b 0 Z0=42.5 TD=3.6399e-10
Rl b 0 42.5
.tran 5.000e-12 5.0800e-08
.control
run
wrdata out_pcie_tx_matched.txt v(b)
quit
.endc
.end
